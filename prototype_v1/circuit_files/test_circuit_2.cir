* KiCad schematic - GaN Half-Bridge Test Circuit
.lib /home/tatsat/whb/github/pyNgSpiceLab/prototype_v1/circuit_files/GaN_PSpice_GS61008T_L1V4P1_ASA.lib
Lnet1 DC_1 HS 10n
C1 HS 0 6u
XQ1 HS Q1_Gate SW_Node Q1_Gate GaN_PSpice_GS61008T_L1V4P1
XQ2 HS Q2_Gate SW_Node Q2_Gate GaN_PSpice_GS61008T_L1V4P1
XQ3 SW_Node Q3_Gate 0 Q3_Gate GaN_PSpice_GS61008T_L1V4P1
XQ4 SW_Node Q4_Gate 0 Q4_Gate GaN_PSpice_GS61008T_L1V4P1
XQ5 SW_Node Q5_Gate 0 Q5_Gate GaN_PSpice_GS61008T_L1V4P1
R1 D_HS Q1_Gate 5.1
R2 Q2_Gate D_HS 5.1
R3 D_LS Q3_Gate 10
R4 D_LS Q4_Gate 10
R5 D_LS Q5_Gate 10
L1 SW_Node Load 129u
C2 Load 0 1.5u
R42 Load 0 5.8
VHS1 D_HS SW_Node PULSE( 0 6 40n 2n 2n 1.739109u 3.486219u)   ; HS Gate voltage
VLS1 D_LS 0 PULSE(0 6 1.803109u 2n 2n 1.703109u 3.486219u)  ; LS gate  voltager
VLS2 DC_1 0 DC 48 ; Constant voltage source

.end
